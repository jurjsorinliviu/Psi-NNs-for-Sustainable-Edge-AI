// Verilog-A Memristor Model
// Generated by Ψ-HDL Framework
// Physics-Informed Neural Network based compact model

`include "constants.vams"
`include "disciplines.vams"

module memristor_pinn(p, n);
    inout p, n;
    electrical p, n;

    // Model parameters (learned from PINN)
    parameter real R_on = 1e3;      // ON resistance (Ohm)
    parameter real R_off = 1e5;     // OFF resistance (Ohm)
    parameter real alpha = 2.0;     // Nonlinearity exponent
    parameter real tau = 1e-3;      // Time constant (s)
    parameter real V_set = 0.8;     // SET voltage (V)
    parameter real V_reset = -0.6;  // RESET voltage (V)

    // Note: branch voltage/current use the V()/I() access functions, so the
    // working variables are named Vin/Im to avoid shadowing them (OpenVAF).
    real Vin, Im, x, R;
    real dxdt, window;

    analog begin
        // Read terminal voltage
        Vin = V(p, n);

        // Initialize state
        @(initial_step) begin
            x = 0.1;  // Start in OFF state
        end

        // State-dependent resistance
        // R(x) = R_on + (R_off - R_on) * (1-x)^alpha
        R = R_on + (R_off - R_on) * pow(1 - x, alpha);

        // Memristor current (Ohm's law)
        Im = Vin / R;

        // State dynamics (window function model)
        window = x * (1 - x);  // Prevents saturation

        if (Vin > V_set)
            dxdt = (1/tau) * window * (Vin - V_set);
        else if (Vin < V_reset)
            dxdt = (1/tau) * window * (-Vin - abs(V_reset));
        else
            dxdt = 0;

        // Update state
        x = idt(dxdt, 0.1);
        x = (x < 0) ? 0 : ((x > 1) ? 1 : x);  // Clamp to [0,1]

        // Assign current
        I(p, n) <+ Im;
    end
endmodule
