// Verilog-A Neural Network Module
// Auto-generated by Psi-HDL Framework
// Model Type: PsiNN_burgers
// Input Dimension: 2
// Output Dimension: 1
// Total Layers: 4
//
// This module implements a neural network discovered by Psi-NN
// as an analog behavioral model suitable for SPICE simulation.

`include "constants.vams"
`include "disciplines.vams"

module psi_nn_PsiNN_burgers(in0, in1, out0, vdd, vss);
    // Input ports (voltage nodes)
    input in0;
    input in1;

    // Output ports (voltage nodes)
    output out0;

    // Power supply nodes
    input vdd, vss;

    // Declare port types as electrical
    electrical in0;
    electrical in1;
    electrical out0;
    electrical vdd, vss;

    // Neural network parameters (weights and biases)
    // These can be overridden during instantiation

    // Layer 0: layer1 (psi_plus_minus)
    parameter real fc1_1_w0 = 0.0;
    parameter real fc1_1_b0 = 0.0;
    parameter real fc1_3_w0 = 0.0;
    parameter real fc1_3_b0 = 0.0;

    // Layer 1: layer2 (psi_symmetric)
    parameter real fc2_1_w0 = 0.0;
    parameter real fc2_1_b0 = 0.0;
    parameter real fc2_2_w0 = 0.0;
    parameter real fc2_2_b0 = 0.0;
    parameter real fc2_3_w0 = 0.0;
    parameter real fc2_3_b0 = 0.0;

    // Layer 2: layer3 (psi_combination)
    parameter real fc3_1_w0 = 0.0;
    parameter real fc3_1_b0 = 0.0;
    parameter real fc3_2_w0 = 0.0;
    parameter real fc3_2_b0 = 0.0;

    // Layer 3: output (output)
    parameter real output_w0 = 0.0;
    parameter real output_b0 = 0.0;

    // Internal variables (scalar, OpenVAF-compatible)
    real vin0, vin1, vout0, ts, t1, t2, t3, l1, l2, l3;

    analog begin
        // Read input voltages and normalize
        vin0 = V(in0) / 1.0;
        vin1 = V(in1) / 1.0;

        // Forward propagation through network

        // Layer 1: +/- structure with tanh activation
        ts = fc1_1_w0 * vin0 + fc1_1_b0;
        l1 = tanh(ts + fc1_3_w0 * vin1);
        l2 = tanh(ts - fc1_3_w0 * vin1);

        // Layer 2: symmetric weight sharing
        t1 = l1;
        t2 = l2;
        l1 = tanh(fc2_1_w0 * t1 + fc2_1_b0 + fc2_3_w0 * t2 + fc2_3_b0);
        l2 = tanh(fc2_3_w0 * t1 + fc2_3_b0 + fc2_1_w0 * t2 + fc2_1_b0);
        l3 = tanh(fc2_2_w0 * (t1 - t2));

        // Layer 3: combination
        t1 = l1;
        t2 = l2;
        t3 = l3;
        l1 = tanh(fc3_1_w0 * t1 + fc3_1_b0 - (fc3_1_w0 * t2 + fc3_1_b0) + fc3_2_w0 * t3);

        // Layer 4: linear output (odd function, no bias)
        vout0 = output_w0 * l1;

        // Write output voltages
        V(out0) <+ vout0 * 1.0;
    end

endmodule
