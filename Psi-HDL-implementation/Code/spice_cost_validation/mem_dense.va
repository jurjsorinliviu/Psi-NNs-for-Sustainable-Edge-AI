// Auto-generated neural memristor read-characteristic compact model
// mem_dense: explicit forward pass, OpenVAF-compatible scalar literals
`include "constants.vams"
`include "disciplines.vams"

module mem_dense(p, n);
    inout p, n;
    electrical p, n;
    real Vin, h1_0, h1_1, h1_2, h1_3, h1_4, h1_5, h1_6, h1_7, h1_8, h1_9, h1_10, h1_11, h1_12, h1_13, h1_14, h1_15, h2_0, h2_1, h2_2, h2_3, h2_4, h2_5, h2_6, h2_7, h2_8, h2_9, h2_10, h2_11, h2_12, h2_13, h2_14, h2_15, Iout;
    analog begin
        Vin = V(p, n);
        h1_0 = tanh((-2.2428154945e-01)*Vin + (3.0198752880e-01));
        h1_1 = tanh((7.1613812447e-01)*Vin + (3.9765357971e-01));
        h1_2 = tanh((-1.1825051308e+00)*Vin + (-2.8333580494e-01));
        h1_3 = tanh((-1.0867931843e+00)*Vin + (-1.2393756211e-01));
        h1_4 = tanh((-8.3405745029e-01)*Vin + (9.3680523336e-02));
        h1_5 = tanh((2.1217140555e-01)*Vin + (8.5387629271e-01));
        h1_6 = tanh((-1.9357280433e-01)*Vin + (-6.0220591724e-02));
        h1_7 = tanh((1.2391209602e+00)*Vin + (2.5555175543e-01));
        h1_8 = tanh((-3.0411747098e-01)*Vin + (-5.5986404419e-02));
        h1_9 = tanh((5.0779646635e-01)*Vin + (-1.2723275460e-02));
        h1_10 = tanh((-5.0083798170e-01)*Vin + (5.9159034491e-01));
        h1_11 = tanh((-5.7395622134e-03)*Vin + (-9.7719234228e-01));
        h1_12 = tanh((-1.4406645298e+00)*Vin + (-1.5224239230e-01));
        h1_13 = tanh((-8.8823485374e-01)*Vin + (-7.5298056006e-02));
        h1_14 = tanh((-6.2559431791e-01)*Vin + (-2.0048822463e-01));
        h1_15 = tanh((-2.4897101521e-01)*Vin + (8.5402822495e-01));
        h2_0 = tanh((-3.9742690325e-01)*h1_0 + (1.3829164207e-01)*h1_1 + (-5.2480214834e-01)*h1_2 + (-6.1989891529e-01)*h1_3 + (-4.5711737871e-01)*h1_4 + (9.0494625270e-02)*h1_5 + (5.0259526819e-02)*h1_6 + (4.3936413527e-01)*h1_7 + (-1.8865253031e-01)*h1_8 + (2.2899693251e-01)*h1_9 + (-1.8903049827e-01)*h1_10 + (-6.1662457883e-02)*h1_11 + (-5.8561247587e-01)*h1_12 + (-4.7975683212e-01)*h1_13 + (-1.5783037245e-01)*h1_14 + (-6.1966501176e-02)*h1_15 + (-2.4540668726e-01));
        h2_1 = tanh((1.5712550282e-01)*h1_0 + (-3.1160697341e-01)*h1_1 + (5.8376085758e-01)*h1_2 + (6.7376035452e-01)*h1_3 + (4.2479690909e-01)*h1_4 + (1.7594875395e-01)*h1_5 + (2.4186754227e-01)*h1_6 + (-5.3592890501e-01)*h1_7 + (3.1630748510e-01)*h1_8 + (-5.9920537472e-01)*h1_9 + (7.6051846147e-02)*h1_10 + (-3.2835963368e-01)*h1_11 + (5.6210809946e-01)*h1_12 + (4.7778409719e-01)*h1_13 + (2.2595912218e-01)*h1_14 + (3.1403532624e-01)*h1_15 + (2.0143176615e-01));
        h2_2 = tanh((1.0979740322e-01)*h1_0 + (3.7711326033e-02)*h1_1 + (-6.9890312850e-02)*h1_2 + (-4.9902755767e-02)*h1_3 + (5.1444530487e-02)*h1_4 + (2.7655747533e-01)*h1_5 + (-1.7176187038e-01)*h1_6 + (-3.3124670386e-02)*h1_7 + (3.1738709658e-02)*h1_8 + (3.3212205768e-01)*h1_9 + (1.3640816510e-01)*h1_10 + (1.9779407978e-01)*h1_11 + (-3.5394888371e-02)*h1_12 + (-3.3224073052e-01)*h1_13 + (-8.9594893157e-02)*h1_14 + (-1.8292725086e-01)*h1_15 + (-1.7516563833e-01));
        h2_3 = tanh((-2.7886611223e-01)*h1_0 + (3.1188538671e-01)*h1_1 + (9.2785701156e-02)*h1_2 + (-3.7423053384e-01)*h1_3 + (-5.8645628393e-02)*h1_4 + (-2.4243650958e-02)*h1_5 + (-1.1671122164e-02)*h1_6 + (-4.4227018952e-02)*h1_7 + (2.8448708355e-02)*h1_8 + (-1.9888795912e-02)*h1_9 + (-3.5179315601e-03)*h1_10 + (1.3264571130e-01)*h1_11 + (7.5762413442e-02)*h1_12 + (-3.3689700067e-02)*h1_13 + (-3.7793108821e-01)*h1_14 + (-2.1332740784e-01)*h1_15 + (3.2749868929e-02));
        h2_4 = tanh((3.1501628458e-02)*h1_0 + (-6.4671882428e-03)*h1_1 + (-2.0444276929e-01)*h1_2 + (-2.1833950281e-01)*h1_3 + (1.2921048701e-01)*h1_4 + (7.3454834521e-02)*h1_5 + (9.9748009816e-03)*h1_6 + (-1.5365344286e-01)*h1_7 + (-1.9996860623e-01)*h1_8 + (9.0985283256e-02)*h1_9 + (-2.9988965392e-01)*h1_10 + (-1.0206487030e-01)*h1_11 + (-5.1839355379e-02)*h1_12 + (-5.2042562515e-02)*h1_13 + (-1.6357104480e-01)*h1_14 + (4.9295958132e-02)*h1_15 + (-2.0775385201e-02));
        h2_5 = tanh((7.2059221566e-02)*h1_0 + (-3.3808685839e-02)*h1_1 + (5.0592392683e-01)*h1_2 + (6.7202910781e-02)*h1_3 + (2.0069089532e-01)*h1_4 + (1.4044120908e-01)*h1_5 + (1.3784831762e-01)*h1_6 + (-3.1064954400e-01)*h1_7 + (2.2231575847e-01)*h1_8 + (-2.6237481833e-01)*h1_9 + (6.5663136542e-02)*h1_10 + (-6.6319383681e-02)*h1_11 + (7.5333416462e-02)*h1_12 + (1.3563333452e-01)*h1_13 + (2.0128223300e-01)*h1_14 + (7.1800768375e-02)*h1_15 + (1.7547437549e-01));
        h2_6 = tanh((7.4811272323e-02)*h1_0 + (-2.0497478545e-01)*h1_1 + (7.1373708546e-02)*h1_2 + (2.5919508934e-01)*h1_3 + (1.4126956463e-02)*h1_4 + (1.4614811540e-01)*h1_5 + (7.0702664554e-02)*h1_6 + (-5.9837162495e-02)*h1_7 + (-2.2393055260e-02)*h1_8 + (-1.7623944581e-01)*h1_9 + (2.2390894592e-01)*h1_10 + (-5.0096777268e-03)*h1_11 + (4.3670526147e-01)*h1_12 + (3.3815428615e-01)*h1_13 + (3.5621976852e-01)*h1_14 + (1.5557631850e-01)*h1_15 + (1.1491112411e-01));
        h2_7 = tanh((-2.3648287356e-01)*h1_0 + (4.3382264674e-02)*h1_1 + (1.7362304032e-01)*h1_2 + (2.9596885666e-02)*h1_3 + (-1.1143518984e-01)*h1_4 + (-8.7590701878e-02)*h1_5 + (-5.0516355038e-01)*h1_6 + (-1.7224857211e-01)*h1_7 + (-3.3612409234e-01)*h1_8 + (2.3235024512e-01)*h1_9 + (1.4860112965e-01)*h1_10 + (-2.9867208004e-01)*h1_11 + (2.1219025552e-01)*h1_12 + (-1.8256199360e-01)*h1_13 + (-1.1846167594e-01)*h1_14 + (-6.9019474089e-02)*h1_15 + (-8.9853189886e-02));
        h2_8 = tanh((-1.5788088739e-01)*h1_0 + (-1.0468535870e-01)*h1_1 + (-3.1943061948e-01)*h1_2 + (-3.4009021521e-01)*h1_3 + (-1.6302382946e-01)*h1_4 + (-1.2444455177e-01)*h1_5 + (2.3278480396e-02)*h1_6 + (1.3330976665e-01)*h1_7 + (-1.4453172684e-01)*h1_8 + (9.1689392924e-02)*h1_9 + (1.0148429871e-01)*h1_10 + (1.6234956682e-02)*h1_11 + (9.7207844257e-02)*h1_12 + (-3.4157145768e-02)*h1_13 + (-2.9963445663e-01)*h1_14 + (4.0472060442e-02)*h1_15 + (5.1272001117e-02));
        h2_9 = tanh((4.7097936273e-02)*h1_0 + (-1.5777964890e-01)*h1_1 + (2.8306400776e-01)*h1_2 + (-8.8814362884e-02)*h1_3 + (1.3479511440e-01)*h1_4 + (1.6818813980e-02)*h1_5 + (8.3166554570e-02)*h1_6 + (1.0390387848e-02)*h1_7 + (1.3361562788e-01)*h1_8 + (-2.0611694083e-02)*h1_9 + (4.1636016220e-02)*h1_10 + (-1.2441064417e-01)*h1_11 + (-1.0691278428e-01)*h1_12 + (2.5109821558e-01)*h1_13 + (3.0052486062e-01)*h1_14 + (2.5715997815e-01)*h1_15 + (-9.5826633275e-02));
        h2_10 = tanh((-3.8368552923e-01)*h1_0 + (2.2873695195e-01)*h1_1 + (-5.1001286507e-01)*h1_2 + (-4.8676592112e-01)*h1_3 + (-4.1937237978e-01)*h1_4 + (-3.6878265440e-02)*h1_5 + (-1.6940529644e-01)*h1_6 + (2.7495500445e-01)*h1_7 + (-1.5592387319e-01)*h1_8 + (4.7371035814e-01)*h1_9 + (-3.9800161123e-01)*h1_10 + (-1.1648507789e-02)*h1_11 + (-5.1058733463e-01)*h1_12 + (-1.3562984765e-01)*h1_13 + (-3.7606760859e-01)*h1_14 + (1.8526088446e-02)*h1_15 + (-7.3591940105e-02));
        h2_11 = tanh((2.7615069412e-03)*h1_0 + (1.3560745120e-01)*h1_1 + (-1.4349034429e-01)*h1_2 + (-1.9906878471e-01)*h1_3 + (-9.8201759160e-02)*h1_4 + (-1.1961670220e-01)*h1_5 + (8.0313511193e-02)*h1_6 + (1.6693493724e-01)*h1_7 + (-2.5284767151e-01)*h1_8 + (7.0023345761e-03)*h1_9 + (9.2347197235e-02)*h1_10 + (-1.2605199218e-01)*h1_11 + (-1.6673134267e-01)*h1_12 + (1.0027641803e-01)*h1_13 + (-4.9304690212e-02)*h1_14 + (-8.7619669735e-02)*h1_15 + (-1.8261051178e-01));
        h2_12 = tanh((-4.5681338757e-02)*h1_0 + (-1.6814738512e-01)*h1_1 + (2.2658908367e-01)*h1_2 + (2.5881239772e-01)*h1_3 + (1.4902952313e-01)*h1_4 + (6.4919881523e-02)*h1_5 + (-2.6788190007e-02)*h1_6 + (-1.9013834000e-01)*h1_7 + (2.4658545852e-01)*h1_8 + (-1.1626477540e-01)*h1_9 + (3.1898114085e-01)*h1_10 + (-2.8801202774e-01)*h1_11 + (4.5555466413e-01)*h1_12 + (1.1889630556e-01)*h1_13 + (2.7427533269e-01)*h1_14 + (2.2592967749e-01)*h1_15 + (1.8640147522e-02));
        h2_13 = tanh((9.8521284759e-02)*h1_0 + (2.6787286997e-01)*h1_1 + (-1.4333204925e-01)*h1_2 + (-8.3465620875e-02)*h1_3 + (4.4022511691e-02)*h1_4 + (-1.3290736079e-01)*h1_5 + (1.4912523329e-01)*h1_6 + (-1.7726504803e-01)*h1_7 + (-9.1122522950e-02)*h1_8 + (8.3834066987e-02)*h1_9 + (-1.8048553169e-01)*h1_10 + (-8.1503249705e-02)*h1_11 + (1.4892438054e-01)*h1_12 + (-1.7130042613e-01)*h1_13 + (-2.5545692444e-01)*h1_14 + (-5.0899200141e-02)*h1_15 + (1.0581132025e-01));
        h2_14 = tanh((-4.2152383924e-01)*h1_0 + (4.3024834991e-01)*h1_1 + (-5.0143897533e-01)*h1_2 + (-5.5549585819e-01)*h1_3 + (-4.8357129097e-01)*h1_4 + (2.4188800156e-01)*h1_5 + (-7.1329541504e-02)*h1_6 + (5.6850475073e-01)*h1_7 + (-1.9304677844e-01)*h1_8 + (2.7375367284e-01)*h1_9 + (-2.6079800725e-01)*h1_10 + (6.7836478353e-02)*h1_11 + (-2.0015488565e-01)*h1_12 + (-2.8497153521e-01)*h1_13 + (-4.7446271777e-01)*h1_14 + (-2.2288556397e-01)*h1_15 + (-1.9917555153e-01));
        h2_15 = tanh((-3.1790265441e-01)*h1_0 + (1.4831085503e-01)*h1_1 + (-2.6615199447e-01)*h1_2 + (-3.7896791101e-01)*h1_3 + (7.7837757766e-02)*h1_4 + (-1.7027133703e-01)*h1_5 + (-3.2636016607e-02)*h1_6 + (1.7465555668e-01)*h1_7 + (-6.2742874026e-02)*h1_8 + (-3.2478518784e-02)*h1_9 + (-3.4521824121e-01)*h1_10 + (2.4108457565e-01)*h1_11 + (-1.0374235362e-01)*h1_12 + (5.9781707823e-02)*h1_13 + (-2.2018566728e-01)*h1_14 + (-2.8192682192e-02)*h1_15 + (-4.5832868665e-02));
        Iout = (1.1993293883e-03)*((1.5773190558e-01)*h2_0 + (-3.6820688844e-01)*h2_1 + (5.6852485985e-02)*h2_2 + (1.4756081998e-01)*h2_3 + (5.1930565387e-02)*h2_4 + (9.8391070962e-02)*h2_5 + (-1.8456299603e-01)*h2_6 + (6.0149271041e-02)*h2_7 + (-9.3020796776e-03)*h2_8 + (-3.9438754320e-02)*h2_9 + (1.5271894634e-01)*h2_10 + (-9.5628211275e-03)*h2_11 + (2.2087927163e-01)*h2_12 + (7.6116040349e-02)*h2_13 + (2.2993779182e-01)*h2_14 + (5.8560132980e-02)*h2_15 + (1.6026847064e-02));
        I(p, n) <+ Iout;
    end
endmodule
