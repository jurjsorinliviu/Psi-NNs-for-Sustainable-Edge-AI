// Auto-generated neural memristor read-characteristic compact model
// mem_struct: explicit forward pass, OpenVAF-compatible scalar literals
`include "constants.vams"
`include "disciplines.vams"

module mem_struct(p, n);
    inout p, n;
    electrical p, n;
    real Vin, h1_0, h1_1, h1_2, h1_3, h2_0, h2_1, h2_2, h2_3, Iout;
    analog begin
        Vin = V(p, n);
        h1_0 = tanh((8.3536303043e-01)*Vin + (8.6322203279e-03));
        h1_1 = tanh((1.4988623857e+00)*Vin + (3.3671002835e-02));
        h1_2 = tanh((-1.9581137896e+00)*Vin + (-2.4879803881e-02));
        h1_3 = tanh((-3.8744750619e-01)*Vin + (1.0933640003e+00));
        h2_0 = tanh((1.1694131047e-01)*h1_0 + (-1.0260172933e-01)*h1_1 + (7.3423728347e-02)*h1_2 + (-1.8848654628e-01)*h1_3 + (-3.2826769352e-01));
        h2_1 = tanh((-1.1061017513e+00)*h1_0 + (-1.2084099054e+00)*h1_1 + (7.2545909882e-01)*h1_2 + (3.0893573165e-01)*h1_3 + (-1.7484618723e-01));
        h2_2 = tanh((7.2676533461e-01)*h1_0 + (1.6261612996e-02)*h1_1 + (4.5916706324e-02)*h1_2 + (-1.6771145165e-01)*h1_3 + (3.0720922351e-01));
        h2_3 = tanh((4.8315227032e-01)*h1_0 + (1.0432885885e+00)*h1_1 + (-7.7176433802e-01)*h1_2 + (1.9401091337e-01)*h1_3 + (-2.2514612973e-01));
        Iout = (1.1993293883e-03)*((-2.2294901311e-02)*h2_0 + (-2.6697170734e-01)*h2_1 + (2.0094433427e-01)*h2_2 + (6.5829360485e-01)*h2_3 + (-3.6484990269e-02));
        I(p, n) <+ Iout;
    end
endmodule
